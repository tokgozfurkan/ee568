# Ansys Electronics Desktop project, version 2019.3
materials:
  vacuum: permittivity=1
  steel_1010: permittivity=1 permeability{HUnit=A_per_meter BUnit=tesla curve (0, 0) (238.7, 0.2003) (318.3, 0.3204) (358.1, 0.40045) (437.7, 0.50055) (477.5, 0.5606) (636.6, 0.7908) (795.8, 0.931) (1114.1, 1.1014) (1273.2, 1.2016) (1591.5, 1.302) (2228.2, 1.4028) (3183.1, 1.524) (4774.6, 1.626) (6366.2, 1.698) (7957.7, 1.73) (15915.5, 1.87) (31831, 1.99) (47746.5, 2.04) (63662, 2.07) (79577.5, 2.095) (159155, 2.2) (318310, 2.4)} conductivity=2000000 lande_g_factor=2
  NdFe42-N: CoordinateSystemType=Cylindrical permittivity=1 permeability=1.0997785 conductivity=625000 magnetic_coercivity{Magnitude=-955000A_per_meter DirComp1=1 DirComp2=0 DirComp3=0} lande_g_factor=2
  NdFe42-S: CoordinateSystemType=Cylindrical permittivity=1 permeability=1.0997785 conductivity=625000 magnetic_coercivity{Magnitude=-955000A_per_meter DirComp1=-1 DirComp2=0 DirComp3=0} lande_g_factor=2
  copper: permeability=0.999991 conductivity=58000000

design Q1 (Maxwell 2D, Magnetostatic, XY geometry, model units mm)
geometry:
  SlotCore1 [steel_1010] = user_primitive(RMxprt/SlotCore.dll, DiaGap=110mm, DiaYoke=253mm, Length=0mm, Skew=0deg, Slots=36, SlotType=4, Hs0=1mm, Hs01=0mm, Hs1=2.5mm, Hs2=36.5mm, Bs0=4.8mm, Bs1=4.8mm, Bs2=0mm, Rs=0mm, FilletType=0, HalfSlot=0, SegAngle=15deg, LenRegion=200mm, InfoCore=0)
  PMCore1 [steel_1010] = user_primitive(RMxprt/PMCore.dll, DiaGap=108mm, DiaYoke=20mm, Length=0mm, Poles=4, PoleType=1, Embrace=0.8, ThickMag=4mm, WidthMag=45mm, Offset=0mm, Bridge=2mm, Rib=3mm, LenRegion=200mm, InfoCore=0)
  PMCore2 [NdFe42-N] = user_primitive(RMxprt/PMCore.dll, DiaGap=108mm, DiaYoke=20mm, Length=0mm, Poles=4, PoleType=1, Embrace=0.8, ThickMag=4mm, WidthMag=45mm, Offset=0mm, Bridge=2mm, Rib=3mm, LenRegion=200mm, InfoCore=2)
  PMCore3 [NdFe42-S] = user_primitive(RMxprt/PMCore.dll, DiaGap=108mm, DiaYoke=20mm, Length=0mm, Poles=4, PoleType=1, Embrace=0.8, ThickMag=4mm, WidthMag=45mm, Offset=0mm, Bridge=2mm, Rib=3mm, LenRegion=200mm, InfoCore=2)
  PMCore4 [NdFe42-N] = user_primitive(RMxprt/PMCore.dll, DiaGap=108mm, DiaYoke=20mm, Length=0mm, Poles=4, PoleType=1, Embrace=0.8, ThickMag=4mm, WidthMag=45mm, Offset=0mm, Bridge=2mm, Rib=3mm, LenRegion=200mm, InfoCore=2)
  PMCore5 [NdFe42-S] = user_primitive(RMxprt/PMCore.dll, DiaGap=108mm, DiaYoke=20mm, Length=0mm, Poles=4, PoleType=1, Embrace=0.8, ThickMag=4mm, WidthMag=45mm, Offset=0mm, Bridge=2mm, Rib=3mm, LenRegion=200mm, InfoCore=2)
  PMCore3.rotate(axis=Z, angle=90deg)
  PMCore4.rotate(axis=Z, angle=180deg)
  PMCore5.rotate(axis=Z, angle=-90deg)
  Circle1 [vacuum] = circle(normal=Z, centre=(0mm, 0mm, 0mm), radius=212.60292mm)
  Circle2 [vacuum] = circle(normal=Z, centre=(0mm, 0mm, 0mm), radius=54.5mm)
  Polyline1 = polyline(z=0mm, xy in mm: (54.5, 0) (3.3371625e-15, 54.5) (-54.5, 6.6743251e-15), AngularArc from point 0 over 3 centre=(0mm, 0mm, 0mm) angle=180deg plane=XY)
boundaries and excitations:
  VectorPotential1: Vector Potential Edges=Circle1.edge(1 of 1) Value=0
mesh:
  initial mesh: MeshMethod=AnsoftTAU
setups:
  Setup1: Magnetostatic MaximumPasses=10 MinimumPasses=2 MinimumConvergedPasses=1 PercentRefinement=30 PercentError=1 ConstantDelta=0s NonLinearResidual=0.0001
field calculator expressions:
  Br = B_Vector | 2D_Normal | Dot
field plots:
  Mag_B1: B over SlotCore1 on Setup1 : LastAdaptive
reports:
  Calculator Expressions Plot 1: Br vs Distance on Setup1 : LastAdaptive

design Q3 (Maxwell 2D, Magnetostatic, XY geometry, model units mm)
geometry:
  SlotCore1 [steel_1010] = user_primitive(RMxprt/SlotCore.dll, DiaGap=68mm, DiaYoke=160mm, Length=0mm, Skew=0deg, Slots=36, SlotType=4, Hs0=1mm, Hs01=0mm, Hs1=2.5mm, Hs2=23mm, Bs0=2.97mm, Bs1=2.97mm, Bs2=0mm, Rs=0mm, FilletType=0, HalfSlot=0, SegAngle=15deg, LenRegion=200mm, InfoCore=0)
  PMCore1 [steel_1010] = user_primitive(RMxprt/PMCore.dll, DiaGap=66mm, DiaYoke=20mm, Length=0mm, Poles=4, PoleType=1, Embrace=0.8, ThickMag=4mm, WidthMag=45mm, Offset=0mm, Bridge=2mm, Rib=3mm, LenRegion=200mm, InfoCore=0)
  PMCore2 [NdFe42-N] = user_primitive(RMxprt/PMCore.dll, DiaGap=66mm, DiaYoke=20mm, Length=0mm, Poles=4, PoleType=1, Embrace=0.8, ThickMag=4mm, WidthMag=45mm, Offset=0mm, Bridge=2mm, Rib=3mm, LenRegion=200mm, InfoCore=2)
  PMCore3 [NdFe42-S] = user_primitive(RMxprt/PMCore.dll, DiaGap=66mm, DiaYoke=20mm, Length=0mm, Poles=4, PoleType=1, Embrace=0.8, ThickMag=4mm, WidthMag=45mm, Offset=0mm, Bridge=2mm, Rib=3mm, LenRegion=200mm, InfoCore=2)
  PMCore4 [NdFe42-N] = user_primitive(RMxprt/PMCore.dll, DiaGap=66mm, DiaYoke=20mm, Length=0mm, Poles=4, PoleType=1, Embrace=0.8, ThickMag=4mm, WidthMag=45mm, Offset=0mm, Bridge=2mm, Rib=3mm, LenRegion=200mm, InfoCore=2)
  PMCore5 [NdFe42-S] = user_primitive(RMxprt/PMCore.dll, DiaGap=66mm, DiaYoke=20mm, Length=0mm, Poles=4, PoleType=1, Embrace=0.8, ThickMag=4mm, WidthMag=45mm, Offset=0mm, Bridge=2mm, Rib=3mm, LenRegion=200mm, InfoCore=2)
  PMCore3.rotate(axis=Z, angle=90deg)
  PMCore4.rotate(axis=Z, angle=180deg)
  PMCore5.rotate(axis=Z, angle=-90deg)
  Circle1 [vacuum] = circle(normal=Z, centre=(0mm, 0mm, 0mm), radius=212.60292mm)
  Polyline1 = polyline(z=0mm, xy in mm: (33.5, 0) (2.0512834e-15, 33.5) (-33.5, 4.1025668e-15), AngularArc from point 0 over 3 centre=(0mm, 0mm, 0mm) angle=180deg plane=XY)
  [SlotCore1, PMCore1..PMCore5, Polyline1].rotate(axis=Z, angle=5deg)
boundaries and excitations:
  VectorPotential1: Vector Potential Edges=Circle1.edge(1 of 1) Value=0
mesh:
  initial mesh: MeshMethod=AnsoftTAU
setups:
  Setup1: Magnetostatic MaximumPasses=10 MinimumPasses=2 MinimumConvergedPasses=1 PercentRefinement=30 PercentError=1 NonLinearResidual=0.0001
field calculator expressions:
  Br = B_Vector | 2D_Normal | Dot
field plots:
  Mag_B1: B over SlotCore1 on Setup1 : LastAdaptive
reports:
  Calculator Expressions Plot 1: Br vs Distance on Setup1 : LastAdaptive

design Q4 (Maxwell 2D, Transient, XY geometry, model units mm)
options: ModelDepth=1meter Multiplier=1
geometry:
  SlotCore1 [steel_1010] = user_primitive(RMxprt/SlotCore.dll, DiaGap=68mm, DiaYoke=160mm, Length=0mm, Skew=0deg, Slots=36, SlotType=4, Hs0=1mm, Hs01=0mm, Hs1=2.5mm, Hs2=23mm, Bs0=2.97mm, Bs1=2.97mm, Bs2=0mm, Rs=0mm, FilletType=0, HalfSlot=0, SegAngle=15deg, LenRegion=200mm, InfoCore=0)
  PMCore1 [steel_1010] = user_primitive(RMxprt/PMCore.dll, DiaGap=66mm, DiaYoke=20mm, Length=0mm, Poles=4, PoleType=1, Embrace=0.8, ThickMag=4mm, WidthMag=45mm, Offset=0mm, Bridge=2mm, Rib=3mm, LenRegion=200mm, InfoCore=0)
  PMCore2 [NdFe42-N] = user_primitive(RMxprt/PMCore.dll, DiaGap=66mm, DiaYoke=20mm, Length=0mm, Poles=4, PoleType=1, Embrace=0.8, ThickMag=4mm, WidthMag=45mm, Offset=0mm, Bridge=2mm, Rib=3mm, LenRegion=200mm, InfoCore=2)
  PMCore3 [NdFe42-S] = user_primitive(RMxprt/PMCore.dll, DiaGap=66mm, DiaYoke=20mm, Length=0mm, Poles=4, PoleType=1, Embrace=0.8, ThickMag=4mm, WidthMag=45mm, Offset=0mm, Bridge=2mm, Rib=3mm, LenRegion=200mm, InfoCore=2)
  PMCore4 [NdFe42-N] = user_primitive(RMxprt/PMCore.dll, DiaGap=66mm, DiaYoke=20mm, Length=0mm, Poles=4, PoleType=1, Embrace=0.8, ThickMag=4mm, WidthMag=45mm, Offset=0mm, Bridge=2mm, Rib=3mm, LenRegion=200mm, InfoCore=2)
  PMCore5 [NdFe42-S] = user_primitive(RMxprt/PMCore.dll, DiaGap=66mm, DiaYoke=20mm, Length=0mm, Poles=4, PoleType=1, Embrace=0.8, ThickMag=4mm, WidthMag=45mm, Offset=0mm, Bridge=2mm, Rib=3mm, LenRegion=200mm, InfoCore=2)
  PMCore3.rotate(axis=Z, angle=90deg)
  PMCore4.rotate(axis=Z, angle=180deg)
  PMCore5.rotate(axis=Z, angle=-90deg)
  Circle1 [vacuum] = circle(normal=Z, centre=(0mm, 0mm, 0mm), radius=212.60292mm)
  Polyline1 = polyline(z=0mm, xy in mm: (33.5, 0) (2.0512834e-15, 33.5) (-33.5, 4.1025668e-15), AngularArc from point 0 over 3 centre=(0mm, 0mm, 0mm) angle=180deg plane=XY)
  [SlotCore1, PMCore1..PMCore5, Polyline1].rotate(axis=Z, angle=5deg)
  Rectangle1 = rectangle(corner=(34mm, 1mm, 0mm), x_size=23mm, y_size=-2mm)
  Rectangle2 [copper] = rectangle(corner=(42.5mm, 1.5mm, 0mm), x_size=14.5mm, y_size=-0.5mm)
  Rectangle4 = rectangle(corner=(42.5mm, -1mm, 0mm), x_size=14.5mm, y_size=-0.5mm)
  Rectangle2.unite(Rectangle1, Rectangle4)
  Rectangle2_1, Rectangle2_2 [copper] = Rectangle2.duplicate_around_axis(axis=Z, angle=10deg, total=3)
  Rectangle2_3..Rectangle2_13 [copper] = Rectangle2.duplicate_around_axis(axis=Z, angle=90deg, total=12)
  Rectangle2_1_1..Rectangle2_1_11 [copper] = Rectangle2_1.duplicate_around_axis(axis=Z, angle=90deg, total=12)
  Rectangle2_2_1..Rectangle2_2_11 [copper] = Rectangle2_2.duplicate_around_axis(axis=Z, angle=90deg, total=12)
  Rectangle2_10_1, Rectangle2_10_2 [copper] = Rectangle2_10.duplicate_around_axis(axis=Z, angle=30deg, total=3)
  Rectangle2_1_4_1, Rectangle2_1_4_2 [copper] = Rectangle2_1_4.duplicate_around_axis(axis=Z, angle=30deg, total=3)
  Rectangle2_2_8_1, Rectangle2_2_8_2 [copper] = Rectangle2_2_8.duplicate_around_axis(axis=Z, angle=30deg, total=3)
  Rectangle2_11_1, Rectangle2_11_2 [copper] = Rectangle2_11.duplicate_around_axis(axis=Z, angle=30deg, total=3)
  Rectangle2_1_9_1, Rectangle2_1_9_2 [copper] = Rectangle2_1_9.duplicate_around_axis(axis=Z, angle=30deg, total=3)
  Rectangle2_2_1_1, Rectangle2_2_1_2 [copper] = Rectangle2_2_1.duplicate_around_axis(axis=Z, angle=30deg, total=3)
  Rectangle2_12_1, Rectangle2_12_2 [copper] = Rectangle2_12.duplicate_around_axis(axis=Z, angle=30deg, total=3)
  Rectangle2_1_10_1, Rectangle2_1_10_2 [copper] = Rectangle2_1_10.duplicate_around_axis(axis=Z, angle=30deg, total=3)
  Rectangle2_2_10_1, Rectangle2_2_10_2 [copper] = Rectangle2_2_10.duplicate_around_axis(axis=Z, angle=30deg, total=3)
  Rectangle2_13_1, Rectangle2_13_2 [copper] = Rectangle2_13.duplicate_around_axis(axis=Z, angle=30deg, total=3)
  Rectangle2_1_3_1, Rectangle2_1_3_2 [copper] = Rectangle2_1_3.duplicate_around_axis(axis=Z, angle=30deg, total=3)
  Rectangle2_2_3_1, Rectangle2_2_3_2 [copper] = Rectangle2_2_3.duplicate_around_axis(axis=Z, angle=30deg, total=3)
  Circle2 [vacuum] = circle(normal=Z, centre=(0mm, 0mm, 0mm), radius=33.5mm)
motion:
  MotionSetup1: Band Move_Type=Rotate Coordinate_System=Global Axis=Z Is_Positive=true InitPos=0deg Angular_Velocity=1500rpm Objects=Circle2
  Moving1: Moving Objects=[PMCore1..PMCore5, Polyline1]
boundaries and excitations:
  VectorPotential1: Vector Potential Edges=Circle1.edge(1 of 1) Value=0
  A1: Coil Objects=Rectangle2 Conductor_number=1 Winding=Phase-A PolarityType=Positive
  A2: Coil Objects=Rectangle2_1 Conductor_number=1 Winding=Phase-A PolarityType=Positive
  A3: Coil Objects=Rectangle2_2 Conductor_number=1 Winding=Phase-A PolarityType=Positive
  A_3: Coil Objects=Rectangle2_11 Conductor_number=1 Winding=Phase-A PolarityType=Negative
  A_4: Coil Objects=Rectangle2_1_9 Conductor_number=1 Winding=Phase-A PolarityType=Negative
  A_5: Coil Objects=Rectangle2_2_1 Conductor_number=1 Winding=Phase-A PolarityType=Negative
  A_6: Coil Objects=Rectangle2_9 Conductor_number=1 Winding=Phase-A PolarityType=Negative
  A_7: Coil Objects=Rectangle2_1_3 Conductor_number=1 Winding=Phase-A PolarityType=Negative
  A_8: Coil Objects=Rectangle2_2_3 Conductor_number=1 Winding=Phase-A PolarityType=Negative
  A_9: Coil Objects=Rectangle2_12 Conductor_number=1 Winding=Phase-A PolarityType=Positive
  A_10: Coil Objects=Rectangle2_1_10 Conductor_number=1 Winding=Phase-A PolarityType=Positive
  A_11: Coil Objects=Rectangle2_2_10 Conductor_number=1 Winding=Phase-A PolarityType=Positive
  Rectangle2_12_1: Coil Objects=Rectangle2_12_1 Conductor_number=1 Winding=Phase-B PolarityType=Negative
  Rectangle2_1_10_1: Coil Objects=Rectangle2_1_10_1 Conductor_number=1 Winding=Phase-B PolarityType=Negative
  Rectangle2_2_10_1: Coil Objects=Rectangle2_2_10_1 Conductor_number=1 Winding=Phase-B PolarityType=Negative
  Rectangle2_10_1: Coil Objects=Rectangle2_10_1 Conductor_number=1 Winding=Phase-B PolarityType=Negative
  Rectangle2_1_4_1: Coil Objects=Rectangle2_1_4_1 Conductor_number=1 Winding=Phase-B PolarityType=Negative
  Rectangle2_2_8_1: Coil Objects=Rectangle2_2_8_1 Conductor_number=1 Winding=Phase-B PolarityType=Negative
  Rectangle2_11_1: Coil Objects=Rectangle2_11_1 Conductor_number=1 Winding=Phase-B PolarityType=Positive
  Rectangle2_1_9_1: Coil Objects=Rectangle2_1_9_1 Conductor_number=1 Winding=Phase-B PolarityType=Positive
  Rectangle2_2_1_1: Coil Objects=Rectangle2_2_1_1 Conductor_number=1 Winding=Phase-B PolarityType=Positive
  Rectangle2_13_1: Coil Objects=Rectangle2_13_1 Conductor_number=1 Winding=Phase-B PolarityType=Positive
  Rectangle2_1_3_1: Coil Objects=Rectangle2_1_3_1 Conductor_number=1 Winding=Phase-B PolarityType=Positive
  Rectangle2_2_3_1: Coil Objects=Rectangle2_2_3_1 Conductor_number=1 Winding=Phase-B PolarityType=Positive
  C_1: Coil Objects=Rectangle2_10_2 Conductor_number=1 Winding=Phase-C PolarityType=Positive
  C_2: Coil Objects=Rectangle2_1_4_2 Conductor_number=1 Winding=Phase-C PolarityType=Positive
  C_3: Coil Objects=Rectangle2_2_8_2 Conductor_number=1 Winding=Phase-C PolarityType=Positive
  C_4: Coil Objects=Rectangle2_12_2 Conductor_number=1 Winding=Phase-C PolarityType=Positive
  C_5: Coil Objects=Rectangle2_1_10_2 Conductor_number=1 Winding=Phase-C PolarityType=Positive
  C_6: Coil Objects=Rectangle2_2_10_2 Conductor_number=1 Winding=Phase-C PolarityType=Positive
  C_7: Coil Objects=Rectangle2_2_3_2 Conductor_number=1 Winding=Phase-C PolarityType=Negative
  C_8: Coil Objects=Rectangle2_1_3_2 Conductor_number=1 Winding=Phase-C PolarityType=Negative
  C_9: Coil Objects=Rectangle2_13_2 Conductor_number=1 Winding=Phase-C PolarityType=Negative
  C_10: Coil Objects=Rectangle2_11_2 Conductor_number=1 Winding=Phase-C PolarityType=Negative
  C_11: Coil Objects=Rectangle2_1_9_2 Conductor_number=1 Winding=Phase-C PolarityType=Negative
  C_12: Coil Objects=Rectangle2_2_1_2 Conductor_number=1 Winding=Phase-C PolarityType=Negative
  Phase-A: Winding Group Type=Current IsSolid=false Current=2.5*sqrt(2)*sin(2*pi*50*time) ParallelBranchesNum=111
  Phase-B: Winding Group Type=Current IsSolid=false Current=2.5*sqrt(2)*sin(2*pi*50*time) ParallelBranchesNum=111
  Phase-C: Winding Group Type=Current IsSolid=false Current=2.5*sqrt(2)*sin(2*pi*50*time) ParallelBranchesNum=111
mesh:
  Length1: LengthBased Objects=[SlotCore1, PMCore1..PMCore5, Rectangle2, Rectangle2_1..Rectangle2_13, Rectangle2_1_1..Rectangle2_1_11, Rectangle2_2_1..Rectangle2_2_11, Rectangle2_10_1, Rectangle2_10_2, Rectangle2_1_4_1, Rectangle2_1_4_2, Rectangle2_2_8_1, Rectangle2_2_8_2, Rectangle2_11_1, Rectangle2_11_2, Rectangle2_1_9_1, Rectangle2_1_9_2, Rectangle2_2_1_1, Rectangle2_2_1_2, Rectangle2_12_1, Rectangle2_12_2, Rectangle2_1_10_1, Rectangle2_1_10_2, Rectangle2_2_10_1, Rectangle2_2_10_2, Rectangle2_13_1, Rectangle2_13_2, Rectangle2_1_3_1, Rectangle2_1_3_2, Rectangle2_2_3_1, Rectangle2_2_3_2] MaxLength=0.1mm
  initial mesh: MeshMethod=AnsoftTAU
setups:
  Setup1: Transient NonlinearSolverResidual=0.0001 StopTime=1s TimeStep="(1/40) ns" SaveFieldsType=Custom SweepRanges{point 1s} NumberSolveSteps=1 RangeStart=0s RangeEnd=0.1s InitialTimeStep=0.002s MinTimeStep=0.001s MaxTimeStep=0.003s TimeStepErrTolerance=0.0001
