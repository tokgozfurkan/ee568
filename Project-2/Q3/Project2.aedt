# Ansys Electronics Desktop project, version 2019.3
materials:
  vacuum: permittivity=1
  M19_24G: permeability{HUnit=A_per_meter BUnit=tesla curve (0, 0) (22.28, 0.05) (25.46, 0.1) (31.83, 0.15) (47.74, 0.36) (63.66, 0.54) (79.57, 0.65) (159.15, 0.99) (318.3, 1.2) (477.46, 1.28) (636.61, 1.33) (795.77, 1.36) (1591.5, 1.44) (3183, 1.52) (4774.6, 1.58) (6366.1, 1.63) (7957.7, 1.67) (15915, 1.8) (31830, 1.9) (111407, 2) (190984, 2.1) (350138, 2.3) (509292, 2.5)} conductivity=1960000 core_loss_type="Electrical Steel" core_loss_kh=164.2 core_loss_kc=1.3 core_loss_ke=1.72 mass_density=7650
  M19_29G: permeability{HUnit=A_per_meter BUnit=tesla curve (0, 0) (22.28, 0.05) (25.46, 0.1) (31.83, 0.15) (47.74, 0.36) (63.66, 0.54) (79.57, 0.65) (159.15, 0.99) (318.3, 1.2) (477.46, 1.28) (636.61, 1.33) (795.77, 1.36) (1591.5, 1.44) (3183, 1.52) (4774.6, 1.58) (6366.1, 1.63) (7957.7, 1.67) (15915, 1.8) (31830, 1.9) (111407, 2) (190984, 2.1) (350138, 2.3) (509292, 2.5)} conductivity=1960000 core_loss_type="Electrical Steel" core_loss_kh=164.2 core_loss_kc=0.409 mass_density=7650
  NdFe35: permittivity=1 permeability=1.0997785 conductivity=625000 magnetic_coercivity{Magnitude=-890000A_per_meter DirComp1=1 DirComp2=0 DirComp3=0} lande_g_factor=2 mass_density=7400
  M19_29G_2DSF0.950: permeability{HUnit=A_per_meter BUnit=tesla curve (0, 0) (22.28, 0.0475014) (25.46, 0.0950016) (31.83, 0.142502) (47.74, 0.342003) (63.66, 0.513004) (79.57, 0.617505) (159.15, 0.94051) (318.3, 1.14002) (477.46, 1.21603) (636.61, 1.26354) (795.77, 1.29205) (1591.5, 1.3681) (3183, 1.4442) (4774.6, 1.5013) (6366.1, 1.5489) (7957.7, 1.587) (15915, 1.711) (31830, 1.807) (111407, 1.907) (190984, 2.007) (350138, 2.207) (509292, 2.407) (2100830, 4.407)} conductivity=1960000 core_loss_type="Electrical Steel" core_loss_kh=172.842 core_loss_kc=0.430526 mass_density=7267.5
  NdFe35_2DSF1.000_N: CoordinateSystemType=Cylindrical permeability=1.09978 conductivity=625000 magnetic_coercivity{Magnitude=-890000A_per_meter DirComp1=1 DirComp2=0 DirComp3=0} mass_density=7400
  NdFe35_2DSF1.000_S: CoordinateSystemType=Cylindrical permeability=1.09978 conductivity=625000 magnetic_coercivity{Magnitude=-890000A_per_meter DirComp1=-1 DirComp2=0 DirComp3=0} mass_density=7400
  copper: permeability=0.999991 conductivity=58000000 mass_density=8933

design RMxprtDesign1 (RMxprt, Adjust-Speed Synchronous Machine, model units mm)
variables:
  tooth_width = 10mm
  conductor = 80
  magnet_thickness = 5mm
machine:
  Machine: FrictionLoss=50W WindLoss=50W ReferenceSpeed=600rpm NumberOfPoles=20 RotorPosition=true ControlType=3 CircuitType=Y3
  Circuit: TriggerPulseWidth=120deg TransistorDrop=0V DiodeDrop=0V ModulationIndex=0 CarrierFrequencyTimes=0
  Stator: SkewWidth=0 NumberOfSlots=21 LaminationSectors=0 PressBoardThickness=0mm OuterDiameter=270mm InnerDiameter=180mm Length=135mm StackingFactor=0.95 SteelType=M19_29G SlotType=3
  Rotor: OuterDiameter=176mm InnerDiameter=100mm Length=135mm SteelType=M19_29G PoleType=1 StackingFactor=0.95
  Shaft: MagneticShaft
  Stator Slot: Hs0=0.5mm Hs1=1mm Hs2=25mm Bs0=6mm Bs1=0mm Bs2=0mm Rs=5mm ParallelTooth ToothWidth=tooth_width
  Stator Winding: WindingType=Whole-Coiled WindingLayers=2 ParallelBranches=1 ConductorsPerSlot=conductor CoilPitch=1 EndAdjustment=0mm BaseInnerRadius=0mm TipInnerDiameter=0mm EndClearance=0mm CoilWrap=0mm SlotLiner=0mm WedgeThickness=0mm LayerInsulation=0mm BottomInsulation=0mm LimitedFillFactor=0.75 WdgNumberofPriodicMultipler=1 NumberOfStrands=2 WireWrap=0.5mm InterturnInsulation=0mm WireDiameter=1.024mm WireWidth=0mm WireThickness=0mm Gauge=18
  Rotor Pole: Embrace=0.7 Offset=0mm ShaftDiameter=0mm Bridge=0mm Rib=0mm MagnetThickness=magnet_thickness MagnetWidth=0mm MagnetType=NdFe35
setups:
  Setup1: ASSM Motor RatedOutputPower=8000W RatedVoltage=540V RatedSpeed=600rpm OperatingTemperature=75cel LoadType=ConstPower RatedPowerFactor=0.75
optimetrics:
  ParametricSetup1: Parametric Sim._Setups=[Setup1]
    sweep conductor: LIN 70 90 1
reports:
  Inductance Plot 1: DAxisInductanceL1PlusLadParameter, DAxisReactiveInductanceLadParameter vs conductor on Setup1 : Performance
  Misc. Table 1: StatorSlotFillFactorParameter vs conductor on Setup1 : Performance

design MaxCir2 (Maxwell Circuit)
variables:
  Kle = 1
components:
  Winding_189 = Winding(Name=PhaseA)
  Winding_196 = Winding(Name=PhaseB)
  Winding_203 = Winding(Name=PhaseC)
  Res_210 = Res(Name=A R=1.17093ohm)
  Res_217 = Res(Name=B R=1.17093ohm)
  Res_224 = Res(Name=C R=1.17093ohm)
  Ind_231 = Ind(Name=A L=4.65323e-05H*Kle)
  Ind_238 = Ind(Name=B L=4.65323e-05H*Kle)
  Ind_245 = Ind(Name=C L=4.65323e-05H*Kle)
  Ammeter_252 = Ammeter(Name=IA)
  Ammeter_259 = Ammeter(Name=IB)
  Ammeter_266 = Ammeter(Name=IC)
  VSin_273 = VSin(Va=440.908V VFreq=100 Phase=343.855deg AF=1 Name=A)
  VoltmeterG_280 = VoltmeterG(Name=Va)
  VSin_287 = VSin(Va=440.908V VFreq=100 Phase=103.855deg AF=1 Name=B)
  VoltmeterG_294 = VoltmeterG(Name=Vb)
  VSin_301 = VSin(Va=440.908V VFreq=100 Phase=223.855deg AF=1 Name=C)
  VoltmeterG_308 = VoltmeterG(Name=Vc)
nets:
  0: VSin_301.1, VSin_287.1, VSin_273.1
  net_1: Winding_189.1, Winding_196.1, Winding_203.1
  net_10: Ind_231.0, Ammeter_252.1
  net_11: Ind_238.0, Ammeter_259.1
  net_12: Ind_245.0, Ammeter_266.1
  net_14: Ammeter_252.0, VoltmeterG_280.0, VSin_273.0
  net_16: VoltmeterG_294.0, VSin_287.0, Ammeter_259.0
  net_18: VSin_301.0, VoltmeterG_308.0, Ammeter_266.0
  net_4: Res_210.1, Winding_189.0
  net_5: Winding_196.0, Res_217.1
  net_6: Res_224.1, Winding_203.0
  net_7: Res_210.0, Ind_231.1
  net_8: Ind_238.1, Res_217.0
  net_9: Res_224.0, Ind_245.1

design Maxwell2DDesign5 (Maxwell 2D, Transient, XY geometry, model units mm)
options: ComputeTransientInductance ModelDepth=135mm Multiplier=fractions
variables:
  fractions = 1
  tooth_width = 10mm
  conductor = 80
  magnet_thickness = 5mm
  delta = 16.145236deg
  conds = 40
  R1 = 1.1709259ohm
  Le1 = 4.653229e-05H
geometry:
  Band [vacuum] = user_primitive(RMxprt/Band, DiaGap=178mm, DiaYoke=100mm, Length=0mm, SegAngle=0deg, Fractions=1, HalfAxial=0, InfoCore=0)
  Shaft [M19_29G_2DSF0.950] = user_primitive(RMxprt/Band, DiaGap=178mm, DiaYoke=100mm, Length=0mm, SegAngle=0deg, Fractions=1, HalfAxial=0, InfoCore=100)
  OuterRegion [vacuum] = user_primitive(RMxprt/Band, DiaGap=178mm, DiaYoke=270mm, Length=0mm, SegAngle=0deg, Fractions=fractions, HalfAxial=0, InfoCore=100)
  Tool = user_primitive(RMxprt/Band, DiaGap=178mm, DiaYoke=270mm, Length=0mm, SegAngle=0deg, Fractions=fractions, HalfAxial=0, InfoCore=1)
  Stator [M19_29G_2DSF0.950] = user_primitive(RMxprt/SlotCore, DiaGap=180mm, DiaYoke=270mm, Length=0mm, Skew=0deg, Slots=21, SlotType=3, Hs0=0.5mm, Hs01=0mm, Hs1=1mm, Hs2=25mm, Bs0=6mm, Bs1=17.454782mm, Bs2=24.991069mm, Rs=5mm, FilletType=0, HalfSlot=0, SegAngle=15deg, LenRegion=0mm, InfoCore=0)
  Coil_0 [copper] = user_primitive(RMxprt/LapCoil, DiaGap=180mm, DiaYoke=270mm, Length=0mm, Skew=0deg, Slots=21, SlotType=3, Hs0=0.5mm, Hs1=1mm, Hs2=25mm, Bs0=6mm, Bs1=17.454782mm, Bs2=24.991069mm, Rs=5mm, FilletType=0, Layers=2, CoilPitch=1, EndExt=0mm, SpanExt=0mm, BendAngle=0deg, SegAngle=10deg, LenRegion=0mm, InfoCoil=2)
  Coil_1..Coil_20 [copper] = Coil_0.duplicate_around_axis(axis=Z, angle=17.142857deg, total=21)
  CoilRe_0 [copper] = user_primitive(RMxprt/LapCoil, DiaGap=180mm, DiaYoke=270mm, Length=0mm, Skew=0deg, Slots=21, SlotType=3, Hs0=0.5mm, Hs1=1mm, Hs2=25mm, Bs0=6mm, Bs1=17.454782mm, Bs2=24.991069mm, Rs=5mm, FilletType=0, Layers=2, CoilPitch=1, EndExt=0mm, SpanExt=0mm, BendAngle=0deg, SegAngle=10deg, LenRegion=0mm, InfoCoil=3)
  CoilRe_0.rotate(axis=Z, angle=-17.142857deg)
  CoilRe_1..CoilRe_20 [copper] = CoilRe_0.duplicate_around_axis(axis=Z, angle=17.142857deg, total=21)
  Rotor [M19_29G_2DSF0.950] = user_primitive(RMxprt/PMCore, DiaGap=176mm, DiaYoke=100mm, Length=0mm, Poles=20, PoleType=1, Embrace=0.7, ThickMag=magnet_thickness, WidthMag=0mm, Offset=0mm, Bridge=0mm, Rib=0mm, LenRegion=0mm, InfoCore=0)
  Mag_0 [NdFe35_2DSF1.000_N] = user_primitive(RMxprt/PMCore, DiaGap=176mm, DiaYoke=100mm, Length=0mm, Poles=20, PoleType=1, Embrace=0.7, ThickMag=magnet_thickness, WidthMag=0mm, Offset=0mm, Bridge=0mm, Rib=0mm, LenRegion=0mm, InfoCore=2)
  Mag_1 [NdFe35_2DSF1.000_S], Mag_2 [NdFe35_2DSF1.000_N], Mag_3 [NdFe35_2DSF1.000_S], Mag_4 [NdFe35_2DSF1.000_N], Mag_5 [NdFe35_2DSF1.000_S], Mag_6 [NdFe35_2DSF1.000_N], Mag_7 [NdFe35_2DSF1.000_S], Mag_8 [NdFe35_2DSF1.000_N], Mag_9 [NdFe35_2DSF1.000_S], Mag_10 [NdFe35_2DSF1.000_N], Mag_11 [NdFe35_2DSF1.000_S], Mag_12 [NdFe35_2DSF1.000_N], Mag_13 [NdFe35_2DSF1.000_S], Mag_14 [NdFe35_2DSF1.000_N], Mag_15 [NdFe35_2DSF1.000_S], Mag_16 [NdFe35_2DSF1.000_N], Mag_17 [NdFe35_2DSF1.000_S], Mag_18 [NdFe35_2DSF1.000_N], Mag_19 [NdFe35_2DSF1.000_S] = Mag_0.duplicate_around_axis(axis=Z, angle=18deg, total=20)
  InnerRegion [vacuum] = user_primitive(RMxprt/PMCore, DiaGap=176mm, DiaYoke=100mm, Length=0mm, Poles=20, PoleType=1, Embrace=0.7, ThickMag=magnet_thickness, WidthMag=0mm, Offset=0mm, Bridge=0mm, Rib=0mm, LenRegion=0mm, InfoCore=100)
  Tool_1 = Tool.copy()
  Band.subtract(Tool_1)
  Tool_2 = Tool.copy()
  InnerRegion.subtract(Tool_2)
  Tool_3 = Tool.copy()
  Shaft.subtract(Tool_3)
  Tool_4 = Tool.copy()
  Stator.subtract(Tool_4)
  Tool_5 = Tool.copy()
  Coil_0.subtract(Tool_5)
  Tool_6 = Tool.copy()
  Coil_1.subtract(Tool_6)
  Tool_7 = Tool.copy()
  Coil_2.subtract(Tool_7)
  Tool_8 = Tool.copy()
  Coil_3.subtract(Tool_8)
  Tool_9 = Tool.copy()
  Coil_4.subtract(Tool_9)
  Tool_10 = Tool.copy()
  Coil_5.subtract(Tool_10)
  Tool_11 = Tool.copy()
  Coil_6.subtract(Tool_11)
  Tool_12 = Tool.copy()
  Coil_7.subtract(Tool_12)
  Tool_13 = Tool.copy()
  Coil_8.subtract(Tool_13)
  Tool_14 = Tool.copy()
  Coil_9.subtract(Tool_14)
  Tool_15 = Tool.copy()
  Coil_10.subtract(Tool_15)
  Tool_16 = Tool.copy()
  Coil_11.subtract(Tool_16)
  Tool_17 = Tool.copy()
  Coil_12.subtract(Tool_17)
  Tool_18 = Tool.copy()
  Coil_13.subtract(Tool_18)
  Tool_19 = Tool.copy()
  Coil_14.subtract(Tool_19)
  Tool_20 = Tool.copy()
  Coil_15.subtract(Tool_20)
  Tool_21 = Tool.copy()
  Coil_16.subtract(Tool_21)
  Tool_22 = Tool.copy()
  Coil_17.subtract(Tool_22)
  Tool_23 = Tool.copy()
  Coil_18.subtract(Tool_23)
  Tool_24 = Tool.copy()
  Coil_19.subtract(Tool_24)
  Tool_25 = Tool.copy()
  Coil_20.subtract(Tool_25)
  Tool_26 = Tool.copy()
  CoilRe_0.subtract(Tool_26)
  Tool_27 = Tool.copy()
  CoilRe_1.subtract(Tool_27)
  Tool_28 = Tool.copy()
  CoilRe_2.subtract(Tool_28)
  Tool_29 = Tool.copy()
  CoilRe_3.subtract(Tool_29)
  Tool_30 = Tool.copy()
  CoilRe_4.subtract(Tool_30)
  Tool_31 = Tool.copy()
  CoilRe_5.subtract(Tool_31)
  Tool_32 = Tool.copy()
  CoilRe_6.subtract(Tool_32)
  Tool_33 = Tool.copy()
  CoilRe_7.subtract(Tool_33)
  Tool_34 = Tool.copy()
  CoilRe_8.subtract(Tool_34)
  Tool_35 = Tool.copy()
  CoilRe_9.subtract(Tool_35)
  Tool_36 = Tool.copy()
  CoilRe_10.subtract(Tool_36)
  Tool_37 = Tool.copy()
  CoilRe_11.subtract(Tool_37)
  Tool_38 = Tool.copy()
  CoilRe_12.subtract(Tool_38)
  Tool_39 = Tool.copy()
  CoilRe_13.subtract(Tool_39)
  Tool_40 = Tool.copy()
  CoilRe_14.subtract(Tool_40)
  Tool_41 = Tool.copy()
  CoilRe_15.subtract(Tool_41)
  Tool_42 = Tool.copy()
  CoilRe_16.subtract(Tool_42)
  Tool_43 = Tool.copy()
  CoilRe_17.subtract(Tool_43)
  Tool_44 = Tool.copy()
  CoilRe_18.subtract(Tool_44)
  Tool_45 = Tool.copy()
  CoilRe_19.subtract(Tool_45)
  Tool_46 = Tool.copy()
  CoilRe_20.subtract(Tool_46)
  Tool_47 = Tool.copy()
  Rotor.subtract(Tool_47)
  Tool_48 = Tool.copy()
  Mag_0.subtract(Tool_48)
  Tool_49 = Tool.copy()
  Mag_1.subtract(Tool_49)
  Tool_50 = Tool.copy()
  Mag_2.subtract(Tool_50)
  Tool_51 = Tool.copy()
  Mag_3.subtract(Tool_51)
  Tool_52 = Tool.copy()
  Mag_4.subtract(Tool_52)
  Tool_53 = Tool.copy()
  Mag_5.subtract(Tool_53)
  Tool_54 = Tool.copy()
  Mag_6.subtract(Tool_54)
  Tool_55 = Tool.copy()
  Mag_7.subtract(Tool_55)
  Tool_56 = Tool.copy()
  Mag_8.subtract(Tool_56)
  Tool_57 = Tool.copy()
  Mag_9.subtract(Tool_57)
  Tool_58 = Tool.copy()
  Mag_10.subtract(Tool_58)
  Tool_59 = Tool.copy()
  Mag_11.subtract(Tool_59)
  Tool_60 = Tool.copy()
  Mag_12.subtract(Tool_60)
  Tool_61 = Tool.copy()
  Mag_13.subtract(Tool_61)
  Tool_62 = Tool.copy()
  Mag_14.subtract(Tool_62)
  Tool_63 = Tool.copy()
  Mag_15.subtract(Tool_63)
  Tool_64 = Tool.copy()
  Mag_16.subtract(Tool_64)
  Tool_65 = Tool.copy()
  Mag_17.subtract(Tool_65)
  Tool_66 = Tool.copy()
  Mag_18.subtract(Tool_66)
  Mag_19.subtract(Tool)
motion:
  MotionSetup1: Band Move_Type=Rotate Coordinate_System=Global Axis=Z Is_Positive=true InitPos=10.7143deg Angular_Velocity=600rpm Objects=Band
  Moving1: Moving Objects=[Shaft, Rotor, Mag_0..Mag_19, InnerRegion]
boundaries and excitations:
  VectorPotential1: Vector Potential Edges=OuterRegion.edge(at (0, 135, 0)) Value=0
  PhA_0: Coil Objects=Coil_0 Conductor_number=conds Winding=PhaseA PolarityType=Positive
  PhARe_0: Coil Objects=CoilRe_1 Conductor_number=conds Winding=PhaseA PolarityType=Negative
  PhB_1: Coil Objects=Coil_1 Conductor_number=conds Winding=PhaseB PolarityType=Positive
  PhBRe_1: Coil Objects=CoilRe_2 Conductor_number=conds Winding=PhaseB PolarityType=Negative
  PhBRe_2: Coil Objects=Coil_2 Conductor_number=conds Winding=PhaseB PolarityType=Negative
  PhB_2: Coil Objects=CoilRe_3 Conductor_number=conds Winding=PhaseB PolarityType=Positive
  PhB_3: Coil Objects=Coil_3 Conductor_number=conds Winding=PhaseB PolarityType=Positive
  PhBRe_3: Coil Objects=CoilRe_4 Conductor_number=conds Winding=PhaseB PolarityType=Negative
  PhBRe_4: Coil Objects=Coil_4 Conductor_number=conds Winding=PhaseB PolarityType=Negative
  PhB_4: Coil Objects=CoilRe_5 Conductor_number=conds Winding=PhaseB PolarityType=Positive
  PhB_5: Coil Objects=Coil_5 Conductor_number=conds Winding=PhaseB PolarityType=Positive
  PhBRe_5: Coil Objects=CoilRe_6 Conductor_number=conds Winding=PhaseB PolarityType=Negative
  PhBRe_6: Coil Objects=Coil_6 Conductor_number=conds Winding=PhaseB PolarityType=Negative
  PhB_6: Coil Objects=CoilRe_7 Conductor_number=conds Winding=PhaseB PolarityType=Positive
  PhB_7: Coil Objects=Coil_7 Conductor_number=conds Winding=PhaseB PolarityType=Positive
  PhBRe_7: Coil Objects=CoilRe_8 Conductor_number=conds Winding=PhaseB PolarityType=Negative
  PhC_8: Coil Objects=Coil_8 Conductor_number=conds Winding=PhaseC PolarityType=Positive
  PhCRe_8: Coil Objects=CoilRe_9 Conductor_number=conds Winding=PhaseC PolarityType=Negative
  PhCRe_9: Coil Objects=Coil_9 Conductor_number=conds Winding=PhaseC PolarityType=Negative
  PhC_9: Coil Objects=CoilRe_10 Conductor_number=conds Winding=PhaseC PolarityType=Positive
  PhC_10: Coil Objects=Coil_10 Conductor_number=conds Winding=PhaseC PolarityType=Positive
  PhCRe_10: Coil Objects=CoilRe_11 Conductor_number=conds Winding=PhaseC PolarityType=Negative
  PhCRe_11: Coil Objects=Coil_11 Conductor_number=conds Winding=PhaseC PolarityType=Negative
  PhC_11: Coil Objects=CoilRe_12 Conductor_number=conds Winding=PhaseC PolarityType=Positive
  PhC_12: Coil Objects=Coil_12 Conductor_number=conds Winding=PhaseC PolarityType=Positive
  PhCRe_12: Coil Objects=CoilRe_13 Conductor_number=conds Winding=PhaseC PolarityType=Negative
  PhCRe_13: Coil Objects=Coil_13 Conductor_number=conds Winding=PhaseC PolarityType=Negative
  PhC_13: Coil Objects=CoilRe_14 Conductor_number=conds Winding=PhaseC PolarityType=Positive
  PhC_14: Coil Objects=Coil_14 Conductor_number=conds Winding=PhaseC PolarityType=Positive
  PhCRe_14: Coil Objects=CoilRe_15 Conductor_number=conds Winding=PhaseC PolarityType=Negative
  PhA_15: Coil Objects=Coil_15 Conductor_number=conds Winding=PhaseA PolarityType=Positive
  PhARe_15: Coil Objects=CoilRe_16 Conductor_number=conds Winding=PhaseA PolarityType=Negative
  PhARe_16: Coil Objects=Coil_16 Conductor_number=conds Winding=PhaseA PolarityType=Negative
  PhA_16: Coil Objects=CoilRe_17 Conductor_number=conds Winding=PhaseA PolarityType=Positive
  PhA_17: Coil Objects=Coil_17 Conductor_number=conds Winding=PhaseA PolarityType=Positive
  PhARe_17: Coil Objects=CoilRe_18 Conductor_number=conds Winding=PhaseA PolarityType=Negative
  PhARe_18: Coil Objects=Coil_18 Conductor_number=conds Winding=PhaseA PolarityType=Negative
  PhA_18: Coil Objects=CoilRe_19 Conductor_number=conds Winding=PhaseA PolarityType=Positive
  PhA_19: Coil Objects=Coil_19 Conductor_number=conds Winding=PhaseA PolarityType=Positive
  PhARe_19: Coil Objects=CoilRe_20 Conductor_number=conds Winding=PhaseA PolarityType=Negative
  PhARe_20: Coil Objects=Coil_20 Conductor_number=conds Winding=PhaseA PolarityType=Negative
  PhA_20: Coil Objects=CoilRe_0 Conductor_number=conds Winding=PhaseA PolarityType=Positive
  PhaseA: Winding Group Type=Voltage IsSolid=false Current=0A Resistance=R1 Inductance=Le1 Voltage=440.908*sin(2*pi*100*time+delta) ParallelBranchesNum=1
  PhaseB: Winding Group Type=Voltage IsSolid=false Current=0A Resistance=R1 Inductance=Le1 Voltage=440.908*sin(2*pi*100*time+delta-2*pi/3) ParallelBranchesNum=1
  PhaseC: Winding Group Type=Voltage IsSolid=false Current=0A Resistance=R1 Inductance=Le1 Voltage=440.908*sin(2*pi*100*time+delta-4*pi/3) ParallelBranchesNum=1
  external circuit: "* Design: MaxCir2\"
  Y connection: PhaseA, PhaseB, PhaseC
mesh:
  SurfApprox_Mag: SurfApproxBased Objects=[Mag_0..Mag_19] CurvedSurfaceApproxChoice=ManualSettings SurfDev=0.088mm NormalDev=15deg
  SurfApprox_Main: SurfApproxBased Objects=[Stator, Rotor, Band, OuterRegion, InnerRegion, Shaft] CurvedSurfaceApproxChoice=ManualSettings SurfDev=0.135mm NormalDev=15deg
  initial mesh: MeshMethod=AnsoftTAU
setups:
  Setup1: Transient NonlinearSolverResidual=0.0001 StopTime=50ms TimeStep="(50/500) ms" FastReachSteadyState AutoDetectSteadyState FrequencyOfAddedVoltageSource=100Hz StopCriterion=0.005 SaveFieldsType=Custom SweepRanges{point 20ms point 50ms} NumberSolveSteps=1 RangeStart=0s RangeEnd=0.1s InitialTimeStep=0.002s MinTimeStep=0.001s MaxTimeStep=0.003s TimeStepErrTolerance=0.0001
output variables:
  pos = (Moving1.Position -10.7143 * PI/180) * 10 + PI
  cos0 = cos(pos)
  cos1 = cos(pos-2*PI/3)
  cos2 = cos(pos-4*PI/3)
  sin0 = sin(pos)
  sin1 = sin(pos-2*PI/3)
  sin2 = sin(pos-4*PI/3)
  Lad = L(PhaseA,PhaseA)*cos0 + L(PhaseA,PhaseB)*cos1 + L(PhaseA,PhaseC)*cos2
  Laq = L(PhaseA,PhaseA)*sin0 + L(PhaseA,PhaseB)*sin1 + L(PhaseA,PhaseC)*sin2
  Lbd = L(PhaseB,PhaseA)*cos0 + L(PhaseB,PhaseB)*cos1 + L(PhaseB,PhaseC)*cos2
  Lbq = L(PhaseB,PhaseA)*sin0 + L(PhaseB,PhaseB)*sin1 + L(PhaseB,PhaseC)*sin2
  Lcd = L(PhaseC,PhaseA)*cos0 + L(PhaseC,PhaseB)*cos1 + L(PhaseC,PhaseC)*cos2
  Lcq = L(PhaseC,PhaseA)*sin0 + L(PhaseC,PhaseB)*sin1 + L(PhaseC,PhaseC)*sin2
  L_d = (Lad*cos0 + Lbd*cos1 + Lcd*cos2) * 2/3
  L_q = (Laq*sin0 + Lbq*sin1 + Lcq*sin2) * 2/3
  Flux_d = (FluxLinkage(PhaseA)*cos0+FluxLinkage(PhaseB)*cos1+FluxLinkage(PhaseC)*cos2)*2/3
  Flux_q = (FluxLinkage(PhaseA)*sin0+FluxLinkage(PhaseB)*sin1+FluxLinkage(PhaseC)*sin2)*2/3
  I_d = (Current(PhaseA)*cos0 + Current(PhaseB)*cos1 + Current(PhaseC)*cos2)*2/3
  I_q = (Current(PhaseA)*sin0 + Current(PhaseB)*sin1 + Current(PhaseC)*sin2)*2/3
  Irms = sqrt(I_d^2+I_q^2)/sqrt(2)
  Pcu = 3*Irms^2*R1
reports:
  Torque: Moving1.Torque vs Time on Setup1 : Transient
  Currents: Current(PhaseA), Current(PhaseB), Current(PhaseC) vs Time on Setup1 : Transient
  Induced Voltages: InducedVoltage(PhaseA), InducedVoltage(PhaseB), InducedVoltage(PhaseC) vs Time on Setup1 : Transient
  Flux Linkages: FluxLinkage(PhaseA), FluxLinkage(PhaseB), FluxLinkage(PhaseC) vs Time on Setup1 : Transient
  Voltages: InputVoltage(PhaseA), InputVoltage(PhaseB), InputVoltage(PhaseC) vs Time on Setup1 : Transient
  Powers: InputVoltage(PhaseA)*Current(PhaseA) + InputVoltage(PhaseB)*Current(PhaseB) + InputVoltage(PhaseC)*Current(PhaseC), Moving1.Speed*Moving1.Torque vs Time on Setup1 : Transient
  L_dq: L_d, L_q vs Time on Setup1 : Transient
  Flux_dq: Flux_d, Flux_q vs Time on Setup1 : Transient
  I_dq: I_d, I_q vs Time on Setup1 : Transient
  Line-Line Voltages: InducedVoltage(PhaseA)- InducedVoltage(PhaseB), -InducedVoltage(PhaseA)+ InducedVoltage(PhaseC), InducedVoltage(PhaseB)- InducedVoltage(PhaseC) vs Time on Setup1 : Transient
  Winding Plot 1: mag(InducedVoltage(PhaseA)), mag(InducedVoltage(PhaseA)-InducedVoltage(PhaseB)) vs Freq on Setup1 : Transient
