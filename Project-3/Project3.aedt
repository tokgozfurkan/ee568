# Ansys Electronics Desktop project, version 2019.3
materials:
  vacuum: permittivity=1

design Maxwell2DDesign1 (Maxwell 2D, Magnetostatic, XY geometry, model units mm)
geometry:
  SlotCore1 [vacuum] = user_primitive(RMxprt/SlotCore.dll, DiaGap=110mm, DiaYoke=253mm, Length=100mm, Skew=0deg, Slots=36, SlotType=4, Hs0=1mm, Hs01=0mm, Hs1=2.5mm, Hs2=36.5mm, Bs0=4.8mm, Bs1=4.8mm, Bs2=0mm, Rs=0mm, FilletType=0, HalfSlot=0, SegAngle=15deg, LenRegion=200mm, InfoCore=0)
  PMCore1 [vacuum] = user_primitive(RMxprt/PMCore.dll, DiaGap=108mm, DiaYoke=20mm, Length=100mm, Poles=4, PoleType=1, Embrace=0.8, ThickMag=4mm, WidthMag=45mm, Offset=0mm, Bridge=2mm, Rib=3mm, LenRegion=200mm, InfoCore=0)
  PMCore2 [vacuum] = user_primitive(RMxprt/PMCore.dll, DiaGap=108mm, DiaYoke=20mm, Length=100mm, Poles=4, PoleType=1, Embrace=0.8, ThickMag=4mm, WidthMag=45mm, Offset=0mm, Bridge=2mm, Rib=3mm, LenRegion=200mm, InfoCore=1)
mesh:
  initial mesh: MeshMethod=AnsoftTAU
